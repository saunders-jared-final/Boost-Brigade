* Shuffler PCB (Version 0) - Qspice baseline, full model with parasitics
.lib shuffler_models.lib
Vir1 ra1 R1P 0
Xpvr1 ra1 R2P E1 pvmi_aiko
Dbpr1 R2P R1P dbypass
Cpvr1 R1P R2P {Cpv} RSER=0.1
Vir2 ra2 R2P 0
Xpvr2 ra2 R3P E2 pvmi_aiko
Dbpr2 R3P R2P dbypass
Cpvr2 R2P R3P {Cpv} RSER=0.1
Vir3 ra3 R3P 0
Xpvr3 ra3 0 E3 pvmi_aiko
Dbpr3 0 R3P dbypass
Cpvr3 R3P 0 {Cpv} RSER=0.1
Bref R1P 0 I=if(LOADSEL<0.5, V(R1P)/Rmpp, Icc*min(1, time/200u))
Xcab1p m1p PV1P trace R={Rcab} L={Lcab} RP=50
Xcab1n m1n PV2P trace R={Rcab} L={Lcab} RP=50
Vi1 a1 m1p 0
Xpv1 a1 m1n E1 pvmi_aiko
Dbp1 m1n m1p dbypass
Cpv1 m1p m1n {Cpv} RSER=0.1
Xcab2p m2p PV2P trace R={Rcab} L={Lcab} RP=50
Xcab2n m2n PV3P trace R={Rcab} L={Lcab} RP=50
Vi2 a2 m2p 0
Xpv2 a2 m2n E2 pvmi_aiko
Dbp2 m2n m2p dbypass
Cpv2 m2p m2n {Cpv} RSER=0.1
Xcab3p m3p PV3P trace R={Rcab} L={Lcab} RP=50
Xcab3n m3n 0 trace R={Rcab} L={Lcab} RP=50
Vi3 a3 m3p 0
Xpv3 a3 m3n E3 pvmi_aiko
Dbp3 m3n m3p dbypass
Cpv3 m3p m3n {Cpv} RSER=0.1
Bload PV1P 0 I=if(LOADSEL<0.5, V(PV1P)/Rmpp, Icc*min(1, time/200u))
C1 PV1P c1n 130u RSER={ESR130}
Lc1 c1n PV2P {ESL130} RPAR=5
C2 PV2P c2n 130u RSER={ESR130}
Lc2 c2n PV3P {ESL130} RPAR=5
C3 PV2P c3n 130u RSER={ESR130}
Lc3 c3n PV3P {ESL130} RPAR=5
C4 PV3P c4n 130u RSER={ESR130}
Lc4 c4n 0 {ESL130} RPAR=5
BE1 E1 0 V=table(CASE, 1,1000, 2,1000, 3,1000)
BE2 E2 0 V=table(CASE, 1,1000, 2,600, 3,1000)
BE3 E3 0 V=table(CASE, 1,1000, 2,1000, 3,400)
XtT1 PV1P T1 trace R={R_T1} L={L_T1}
XtB1 PV3P B1 trace R={R_B1} L={L_B1}
LdTA1 T1 dTA1 {Ld_pkg} RPAR=5
LsTA1 sTA1 SWA1 {Ls_pkg} RPAR=5
LdBA1 SWA1 dBA1 {Ld_pkg} RPAR=5
LsBA1 sBA1 B1 {Ls_pkg} RPAR=5
MTA1 dTA1 gTA1 sTA1 sTA1 STD45N10F7
MBA1 dBA1 gBA1 sBA1 sBA1 STD45N10F7
XtgTA1 giTA1 gTA1 trace R={R_gTA1} L={L_gTA1}
RonTA1 ohTA1 giTA1 {Ron}
RoffTA1 olTA1 giTA1 {Roff}
XdTA1 PWM_AH1 PWM_AL1 BOOTA1 SWA1 ohTA1 olTA1 1ED3140
XtgBA1 giBA1 gBA1 trace R={R_gBA1} L={L_gBA1}
RonBA1 ohBA1 giBA1 {Ron}
RoffBA1 olBA1 giBA1 {Roff}
XdBA1 PWM_AL1 PWM_AH1 VREG1 B1 ohBA1 olBA1 1ED3140
RsnTA1 T1 snTA1 {Rsn}
CsnTA1 snTA1 SWA1 {Csn}
RsnBA1 SWA1 snBA1 {Rsn}
CsnBA1 snBA1 B1 {Csn}
LdTB1 T1 dTB1 {Ld_pkg} RPAR=5
LsTB1 sTB1 SWB1 {Ls_pkg} RPAR=5
LdBB1 SWB1 dBB1 {Ld_pkg} RPAR=5
LsBB1 sBB1 B1 {Ls_pkg} RPAR=5
MTB1 dTB1 gTB1 sTB1 sTB1 STD45N10F7
MBB1 dBB1 gBB1 sBB1 sBB1 STD45N10F7
XtgTB1 giTB1 gTB1 trace R={R_gTB1} L={L_gTB1}
RonTB1 ohTB1 giTB1 {Ron}
RoffTB1 olTB1 giTB1 {Roff}
XdTB1 PWM_BH1 PWM_BL1 BOOTB1 SWB1 ohTB1 olTB1 1ED3140
XtgBB1 giBB1 gBB1 trace R={R_gBB1} L={L_gBB1}
RonBB1 ohBB1 giBB1 {Ron}
RoffBB1 olBB1 giBB1 {Roff}
XdBB1 PWM_BL1 PWM_BH1 VREG1 B1 ohBB1 olBB1 1ED3140
RsnTB1 T1 snTB1 {Rsn}
CsnTB1 snTB1 SWB1 {Csn}
RsnBB1 SWB1 snBB1 {Rsn}
CsnBB1 snBB1 B1 {Csn}
XtSWA1 SWA1 SWAL1 trace R={R_SWA1} L={L_SWA1}
XtSWB1 SWBL1 SWB1 trace R={R_SWB1} L={L_SWB1}
XL1 LA2_1 LB2_1 SWBL1 SWAL1 ERUC23-4R1K
VsA1 LA2_1 LA2s_1 0
XtLA1 LA2s_1 LA2t_1 trace R={R_LA1} L={L_LA1}
XsA1 LA2t_1 M1 TMCS1126 RSH={Rtmcs} LSH={Ltmcs}
VsB1 LB2_1 LB2s_1 0
XtLB1 LB2s_1 LB2t_1 trace R={R_LB1} L={L_LB1}
XsB1 LB2t_1 M1 TMCS1126 RSH={Rtmcs} LSH={Ltmcs}
XtM1 M1 PV2P trace R={R_M1} L={L_M1}
Vreg1 VREG1 B1 {Vreg}
CvL1 VREG1 B1 100n RSER=20m
Cv2L1 VREG1 B1 10u RSER=5m
DbA1 bsaA1 BOOTA1 VSSA210
RbA1 bsaA1 VREG1 {Rboot}
CbA1 BOOTA1 SWA1 100n RSER=20m
Cb2A1 BOOTA1 SWA1 10u RSER=5m
DbB1 bsaB1 BOOTB1 VSSA210
RbB1 bsaB1 VREG1 {Rboot}
CbB1 BOOTB1 SWB1 100n RSER=20m
Cb2B1 BOOTB1 SWB1 10u RSER=5m
VpTA1 PWM_AH1 0 PULSE(0 {Vlogic} {0} 5n 5n {Tsw/2-Tdead} {Tsw})
VpBA1 PWM_AL1 0 PULSE(0 {Vlogic} {Tsw/2} 5n 5n {Tsw/2-Tdead} {Tsw})
VpTB1 PWM_BH1 0 PULSE(0 {Vlogic} {Tsw/2} 5n 5n {Tsw/2-Tdead} {Tsw})
VpBB1 PWM_BL1 0 PULSE(0 {Vlogic} {Tsw/2 + Tsw/2} 5n 5n {Tsw/2-Tdead} {Tsw})
ChfA1 T1 hfA1 {3*Chf} RSER=6.66667m
LhfA1 hfA1 B1 0.266667n
ChfB1 T1 hfB1 {3*Chf} RSER=6.66667m
LhfB1 hfB1 B1 0.266667n
XtT2 PV2P T2 trace R={R_T2} L={L_T2}
XtB2 0 B2 trace R={R_B2} L={L_B2}
LdTA2 T2 dTA2 {Ld_pkg} RPAR=5
LsTA2 sTA2 SWA2 {Ls_pkg} RPAR=5
LdBA2 SWA2 dBA2 {Ld_pkg} RPAR=5
LsBA2 sBA2 B2 {Ls_pkg} RPAR=5
MTA2 dTA2 gTA2 sTA2 sTA2 STD45N10F7
MBA2 dBA2 gBA2 sBA2 sBA2 STD45N10F7
XtgTA2 giTA2 gTA2 trace R={R_gTA2} L={L_gTA2}
RonTA2 ohTA2 giTA2 {Ron}
RoffTA2 olTA2 giTA2 {Roff}
XdTA2 PWM_AH2 PWM_AL2 BOOTA2 SWA2 ohTA2 olTA2 1ED3140
XtgBA2 giBA2 gBA2 trace R={R_gBA2} L={L_gBA2}
RonBA2 ohBA2 giBA2 {Ron}
RoffBA2 olBA2 giBA2 {Roff}
XdBA2 PWM_AL2 PWM_AH2 VREG2 B2 ohBA2 olBA2 1ED3140
RsnTA2 T2 snTA2 {Rsn}
CsnTA2 snTA2 SWA2 {Csn}
RsnBA2 SWA2 snBA2 {Rsn}
CsnBA2 snBA2 B2 {Csn}
LdTB2 T2 dTB2 {Ld_pkg} RPAR=5
LsTB2 sTB2 SWB2 {Ls_pkg} RPAR=5
LdBB2 SWB2 dBB2 {Ld_pkg} RPAR=5
LsBB2 sBB2 B2 {Ls_pkg} RPAR=5
MTB2 dTB2 gTB2 sTB2 sTB2 STD45N10F7
MBB2 dBB2 gBB2 sBB2 sBB2 STD45N10F7
XtgTB2 giTB2 gTB2 trace R={R_gTB2} L={L_gTB2}
RonTB2 ohTB2 giTB2 {Ron}
RoffTB2 olTB2 giTB2 {Roff}
XdTB2 PWM_BH2 PWM_BL2 BOOTB2 SWB2 ohTB2 olTB2 1ED3140
XtgBB2 giBB2 gBB2 trace R={R_gBB2} L={L_gBB2}
RonBB2 ohBB2 giBB2 {Ron}
RoffBB2 olBB2 giBB2 {Roff}
XdBB2 PWM_BL2 PWM_BH2 VREG2 B2 ohBB2 olBB2 1ED3140
RsnTB2 T2 snTB2 {Rsn}
CsnTB2 snTB2 SWB2 {Csn}
RsnBB2 SWB2 snBB2 {Rsn}
CsnBB2 snBB2 B2 {Csn}
XtSWA2 SWA2 SWAL2 trace R={R_SWA2} L={L_SWA2}
XtSWB2 SWBL2 SWB2 trace R={R_SWB2} L={L_SWB2}
XL2 LA2_2 LB2_2 SWBL2 SWAL2 ERUC23-4R1K
VsA2 LA2_2 LA2s_2 0
XtLA2 LA2s_2 LA2t_2 trace R={R_LA2} L={L_LA2}
XsA2 LA2t_2 M2 TMCS1126 RSH={Rtmcs} LSH={Ltmcs}
VsB2 LB2_2 LB2s_2 0
XtLB2 LB2s_2 LB2t_2 trace R={R_LB2} L={L_LB2}
XsB2 LB2t_2 M2 TMCS1126 RSH={Rtmcs} LSH={Ltmcs}
XtM2 M2 PV3P trace R={R_M2} L={L_M2}
Vreg2 VREG2 B2 {Vreg}
CvL2 VREG2 B2 100n RSER=20m
Cv2L2 VREG2 B2 10u RSER=5m
DbA2 bsaA2 BOOTA2 VSSA210
RbA2 bsaA2 VREG2 {Rboot}
CbA2 BOOTA2 SWA2 100n RSER=20m
Cb2A2 BOOTA2 SWA2 10u RSER=5m
DbB2 bsaB2 BOOTB2 VSSA210
RbB2 bsaB2 VREG2 {Rboot}
CbB2 BOOTB2 SWB2 100n RSER=20m
Cb2B2 BOOTB2 SWB2 10u RSER=5m
VpTA2 PWM_AH2 0 PULSE(0 {Vlogic} {0} 5n 5n {Tsw/2-Tdead} {Tsw})
VpBA2 PWM_AL2 0 PULSE(0 {Vlogic} {Tsw/2} 5n 5n {Tsw/2-Tdead} {Tsw})
VpTB2 PWM_BH2 0 PULSE(0 {Vlogic} {Tsw/2} 5n 5n {Tsw/2-Tdead} {Tsw})
VpBB2 PWM_BL2 0 PULSE(0 {Vlogic} {Tsw/2 + Tsw/2} 5n 5n {Tsw/2-Tdead} {Tsw})
ChfA2 T2 hfA2 {3*Chf} RSER=6.66667m
LhfA2 hfA2 B2 0.266667n
ChfB2 T2 hfB2 {3*Chf} RSER=6.66667m
LhfB2 hfB2 B2 0.266667n
.param Tsw=5u
.param Tdead=200n
.param Vlogic=3.3
.param Vreg=12
.param Ron=10
.param Roff=4.7
.param Rboot=10
.param Rmpp=8.148
.param Icc=10
.param CASE=1
.param LOADSEL=0
.param Cpv=10n
.param Rcab=6.95m
.param Lcab=750n
.param ESR130=28m
.param ESL130=15n
.param Ld_pkg=1.5n
.param Ls_pkg=3n
.param Rtmcs=0.7m
.param Ltmcs=0.5n
.param Csn=1p
.param Rsn=4.7
.param Chf=1p
.param R_T1=0.518m
.param L_T1=2.4n
.param R_M1=0.149m
.param L_M1=0.29n
.param R_B1=0.11m
.param L_B1=0.23n
.param R_SWA1=0.795m
.param L_SWA1=1.58n
.param R_SWB1=1.56m
.param L_SWB1=5.58n
.param R_LA1=1.35m
.param L_LA1=2.68n
.param R_LB1=0.992m
.param L_LB1=2.32n
.param R_gTA1=5.61m
.param L_gTA1=1.19n
.param R_gBA1=10.8m
.param L_gBA1=1.41n
.param R_gTB1=3.61m
.param L_gTB1=1.04n
.param R_gBB1=5.33m
.param L_gBB1=1.25n
.param R_T2=0.149m
.param L_T2=0.29n
.param R_M2=0.11m
.param L_M2=0.23n
.param R_B2=0.022m
.param L_B2=0.02n
.param R_SWA2=1.87m
.param L_SWA2=2.52n
.param R_SWB2=1.13m
.param L_SWB2=1.04n
.param R_LA2=1m
.param L_LA2=2n
.param R_LB2=1m
.param L_LB2=2n
.param R_gTA2=3.01m
.param L_gTA2=0.91n
.param R_gBA2=4.85m
.param L_gBA2=1.25n
.param R_gTB2=3.39m
.param L_gTB2=0.95n
.param R_gBB2=4.44m
.param L_gBB2=1.1n
.option savepowers
.tran 0 2.5m 2.45m 10n
.step param CASE list 1 2 3
.step param LOADSEL list 0 1
.meas tran vstr AVG V(PV1P)
.meas tran istr AVG I(Bload)
.meas tran pout AVG V(PV1P)*I(Bload)
.meas tran pref AVG V(R1P)*I(Bref)
.meas tran v1 AVG V(PV1P,PV2P)
.meas tran i1 AVG I(Vi1)
.meas tran p1 AVG V(PV1P,PV2P)*I(Vi1)
.meas tran v2 AVG V(PV2P,PV3P)
.meas tran i2 AVG I(Vi2)
.meas tran p2 AVG V(PV2P,PV3P)*I(Vi2)
.meas tran v3 AVG V(PV3P)
.meas tran i3 AVG I(Vi3)
.meas tran p3 AVG V(PV3P)*I(Vi3)
.meas tran vr1 AVG V(R1P,R2P)
.meas tran ir1 AVG I(Vir1)
.meas tran vr2 AVG V(R2P,R3P)
.meas tran ir2 AVG I(Vir2)
.meas tran vr3 AVG V(R3P)
.meas tran ir3 AVG I(Vir3)
.meas tran ila1 AVG I(VsA1)
.meas tran ilb1 AVG I(VsB1)
.meas tran ilapp1 PP I(VsA1)
.meas tran ish1 AVG I(VsA1)+I(VsB1)
.meas tran vswamax1 MAX V(SWA1,B1)
.meas tran vswamin1 MIN V(SWA1,B1)
.meas tran vswbmax1 MAX V(SWB1,B1)
.meas tran pmta1 AVG P(MTA1)
.meas tran pmba1 AVG P(MBA1)
.meas tran pmtb1 AVG P(MTB1)
.meas tran pmbb1 AVG P(MBB1)
.meas tran pconv1 AVG P(MTA1)+P(MBA1)+P(MTB1)+P(MBB1)
.meas tran vgta1 MAX V(gTA1,SWA1)
.meas tran vgtamin1 MIN V(gTA1,SWA1)
.meas tran vboota1 MIN V(BOOTA1,SWA1)
.meas tran tdead1 TRIG V(gBA1,B1)=6 FALL=1 TARG V(gTA1,SWA1)=6 RISE=2
.meas tran psnta1 AVG P(RsnTA1)
.meas tran psnba1 AVG P(RsnBA1)
.meas tran phfa1 AVG P(ChfA1)
.meas tran ila2 AVG I(VsA2)
.meas tran ilb2 AVG I(VsB2)
.meas tran ilapp2 PP I(VsA2)
.meas tran ish2 AVG I(VsA2)+I(VsB2)
.meas tran vswamax2 MAX V(SWA2,B2)
.meas tran vswamin2 MIN V(SWA2,B2)
.meas tran vswbmax2 MAX V(SWB2,B2)
.meas tran pmta2 AVG P(MTA2)
.meas tran pmba2 AVG P(MBA2)
.meas tran pmtb2 AVG P(MTB2)
.meas tran pmbb2 AVG P(MBB2)
.meas tran pconv2 AVG P(MTA2)+P(MBA2)+P(MTB2)+P(MBB2)
.meas tran vgta2 MAX V(gTA2,SWA2)
.meas tran vgtamin2 MIN V(gTA2,SWA2)
.meas tran vboota2 MIN V(BOOTA2,SWA2)
.meas tran tdead2 TRIG V(gBA2,B2)=6 FALL=1 TARG V(gTA2,SWA2)=6 RISE=2
.meas tran psnta2 AVG P(RsnTA2)
.meas tran psnba2 AVG P(RsnBA2)
.meas tran phfa2 AVG P(ChfA2)
.end
