* S10c - BENCH CALIBRATION: NGE103 sources, DL3021 CV 70 V, 100 kHz, shuffler 1 off, shuffler 2 at D2 (13 Oct run)
.lib shuffler_models.lib
Vi1 a1 PV1P 0
Xpv1 a1 PV2P E1 nge_ch
Dbp1 PV2P PV1P dbypass
Cpv1 PV1P PV2P 10n RSER=0.1 IC=22.4
Vi2 a2 PV2P 0
Xpv2 a2 PV3P E2 nge_ch
Dbp2 PV3P PV2P dbypass
Cpv2 PV2P PV3P 10n RSER=0.1 IC=23.8
Vi3 a3 PV3P 0
Xpv3 a3 0 E3 nge_ch
Dbp3 0 PV3P dbypass
Cpv3 PV3P 0 10n RSER=0.1 IC=23.8
Bload PV1P 0 I=if(LOADSEL<0.5, V(PV1P)/Rmpp, if(LOADSEL<1.5, Icc*min(1, time/200u), max(V(PV1P)-VCV,0)/RCV))
BE1 E1 0 V=ILIM1*1000
BE2 E2 0 V=ILIM2*1000
BE3 E3 0 V=1000*if(time<TSHADE, ILIM3, ILIM3*SHADE)
C1 PV1P PV2P 130u RSER=28m IC=22.4
C2 PV2P PV3P 130u RSER=28m IC=23.8
C3 PV2P PV3P 130u RSER=28m IC=23.8
C4 PV3P 0 130u RSER=28m IC=23.8
MTA1 PV1P gTA1 SWA1 SWA1 STD45N10F7
MBA1 SWA1 gBA1 PV3P PV3P STD45N10F7
RonTA1 ohTA1 gTA1 10
RoffTA1 olTA1 gTA1 4.7
XdTA1 PWM_AH1 PWM_AL1 BOOTA1 SWA1 ohTA1 olTA1 1ED3140
RonBA1 ohBA1 gBA1 10
RoffBA1 olBA1 gBA1 4.7
XdBA1 PWM_AL1 PWM_AH1 VREG1 PV3P ohBA1 olBA1 1ED3140
MTB1 PV1P gTB1 SWB1 SWB1 STD45N10F7
MBB1 SWB1 gBB1 PV3P PV3P STD45N10F7
RonTB1 ohTB1 gTB1 10
RoffTB1 olTB1 gTB1 4.7
XdTB1 PWM_BH1 PWM_BL1 BOOTB1 SWB1 ohTB1 olTB1 1ED3140
RonBB1 ohBB1 gBB1 10
RoffBB1 olBB1 gBB1 4.7
XdBB1 PWM_BL1 PWM_BH1 VREG1 PV3P ohBB1 olBB1 1ED3140
XL1 LA2_1 LB2_1 SWB1 SWA1 ERUC23-4R1K
VsA1 LA2_1 LA2s_1 0
XsA1 LA2s_1 PV2P TMCS1126 RSH=0.7m LSH=0.5n
VsB1 LB2_1 LB2s_1 0
XsB1 LB2s_1 PV2P TMCS1126 RSH=0.7m LSH=0.5n
Vreg1 VREG1 PV3P 12
CvL1 VREG1 PV3P 100n RSER=20m
Cv2L1 VREG1 PV3P 10u RSER=5m
DbA1 bsaA1 BOOTA1 VSSA210
RbA1 bsaA1 VREG1 10
CbA1 BOOTA1 SWA1 100n RSER=20m
Cb2A1 BOOTA1 SWA1 10u RSER=5m
DbB1 bsaB1 BOOTB1 VSSA210
RbB1 bsaB1 VREG1 10
CbB1 BOOTB1 SWB1 100n RSER=20m
Cb2B1 BOOTB1 SWB1 10u RSER=5m
BpTA1 PWM_AH1 0 V=if(S1OFF>0.5, 0, if(V(RAMPA) < V(DA1C)-0.02, 3.3, 0))
BpBA1 PWM_AL1 0 V=if(S1OFF>0.5, 0, if(V(RAMPA) > V(DA1C), if(V(RAMPA) < 0.98, 3.3, 0), 0))
BpTB1 PWM_BH1 0 V=if(S1OFF>0.5, 0, if(V(RAMPB) < V(DB1C)-0.02, 3.3, 0))
BpBB1 PWM_BL1 0 V=if(S1OFF>0.5, 0, if(V(RAMPB) > V(DB1C), if(V(RAMPB) < 0.98, 3.3, 0), 0))
MTA2 PV2P gTA2 SWA2 SWA2 STD45N10F7
MBA2 SWA2 gBA2 0 0 STD45N10F7
RonTA2 ohTA2 gTA2 10
RoffTA2 olTA2 gTA2 4.7
XdTA2 PWM_AH2 PWM_AL2 BOOTA2 SWA2 ohTA2 olTA2 1ED3140
RonBA2 ohBA2 gBA2 10
RoffBA2 olBA2 gBA2 4.7
XdBA2 PWM_AL2 PWM_AH2 VREG2 0 ohBA2 olBA2 1ED3140
MTB2 PV2P gTB2 SWB2 SWB2 STD45N10F7
MBB2 SWB2 gBB2 0 0 STD45N10F7
RonTB2 ohTB2 gTB2 10
RoffTB2 olTB2 gTB2 4.7
XdTB2 PWM_BH2 PWM_BL2 BOOTB2 SWB2 ohTB2 olTB2 1ED3140
RonBB2 ohBB2 gBB2 10
RoffBB2 olBB2 gBB2 4.7
XdBB2 PWM_BL2 PWM_BH2 VREG2 0 ohBB2 olBB2 1ED3140
XL2 LA2_2 LB2_2 SWB2 SWA2 ERUC23-4R1K
VsA2 LA2_2 LA2s_2 0
XsA2 LA2s_2 PV3P TMCS1126 RSH=0.7m LSH=0.5n
VsB2 LB2_2 LB2s_2 0
XsB2 LB2s_2 PV3P TMCS1126 RSH=0.7m LSH=0.5n
Vreg2 VREG2 0 12
CvL2 VREG2 0 100n RSER=20m
Cv2L2 VREG2 0 10u RSER=5m
DbA2 bsaA2 BOOTA2 VSSA210
RbA2 bsaA2 VREG2 10
CbA2 BOOTA2 SWA2 100n RSER=20m
Cb2A2 BOOTA2 SWA2 10u RSER=5m
DbB2 bsaB2 BOOTB2 VSSA210
RbB2 bsaB2 VREG2 10
CbB2 BOOTB2 SWB2 100n RSER=20m
Cb2B2 BOOTB2 SWB2 10u RSER=5m
BpTA2 PWM_AH2 0 V=if(V(RAMPA) < V(DA2C)-0.02, 3.3, 0)
BpBA2 PWM_AL2 0 V=if(V(RAMPA) > V(DA2C), if(V(RAMPA) < 0.98, 3.3, 0), 0)
BpTB2 PWM_BH2 0 V=if(V(RAMPB) < V(DB2C)-0.02, 3.3, 0)
BpBB2 PWM_BL2 0 V=if(V(RAMPB) > V(DB2C), if(V(RAMPB) < 0.98, 3.3, 0), 0)
BhsA1 HSA1R 0 V=1.65+0.1*I(VsA1)
RhsA1 HSA1R HSA1 1k
ChsA1 HSA1 0 3.183e-10
BhsB1 HSB1R 0 V=1.65+-0.025*I(VsB1)
RhsB1 HSB1R HSB1 1k
ChsB1 HSB1 0 3.183e-10
BhsA2 HSA2R 0 V=1.65+0.1*I(VsA2)
RhsA2 HSA2R HSA2 1k
ChsA2 HSA2 0 3.183e-10
BhsB2 HSB2R 0 V=1.65+-0.025*I(VsB2)
RhsB2 HSB2R HSB2 1k
ChsB2 HSB2 0 3.183e-10
Vrampa RAMPA 0 PULSE(0 1 0 9.998e-06 1n 1n 1e-05)
Vrampb RAMPB 0 PULSE(0 1 5e-06 9.998e-06 1n 1n 1e-05)
Ven CTRL_EN 0 PWL(0 0 1 0 1 1)
Vref1 VREF1 0 0
Vref2 VREF2 0 PWL(0 0 0.002 0 0.002001 {VSTEP2})
BdDA1 DA1C 0 V=if(V(CTRL_EN)>0.5, V(DA1), 0.5+0)
BdDB1 DB1C 0 V=if(V(CTRL_EN)>0.5, V(DB1), 0.5+0)
BdDA2 DA2C 0 V=if(V(CTRL_EN)>0.5, V(DA2), 0.5+(D2-0.5))
BdDB2 DB2C 0 V=if(V(CTRL_EN)>0.5, V(DB2), 0.5+(D2-0.5))
BtKSCALE KSCALE 0 V=KSCALE
BtMSEL MSEL 0 V=MSEL
BtFILT FILT 0 V=FILT
BtFC FC 0 V=FC
BtNOISE NOISE 0 V=NOISE
BtSAMP SAMP 0 V=SAMP
BtKBERR KBERR 0 V=KBERR
BtFSWP FSWP 0 V=100000
BtVM1SRC VM1SRC 0 V=VM1SRC
BtVSTRP VSTRP 0 V=VSTRP
Ø´Xc «PV1P´d PV2P´d PV3P´d HSA1´d HSB1´d HSA2´d HSB2´d CTRL_EN´d VREF1´d VREF2´d KSCALE´d MSEL´d FILT´d FC´d NOISE´d SAMP´d KBERR´d FSWP´d VM1SRC´d VSTRP´d» «DA1´d DB1´d DA2´d DB2´d RV1´d RV2´d BETA´d STRESS´d IM1R´d IM2R´d» «0»  shuffler_ctrl_dll2 Rout=1 Cout=1p
.param LOADSEL=2 VCV=70 RCV=0.05 Rmpp=1 Icc=1 VSET=25 RCLAMP=0.05 ILIM1=0.8
.param ILIM2=1 ILIM3=1.3 IRR3=1000 SHADE=0.5 TSHADE=1 KSCALE=1 MSEL=0 FILT=0
.param FC=2000 NOISE=0 SAMP=1 KBERR=1 VM1SRC=0 VSTRP=70 VSTEP2=2 DU=0
.param RUN=1 D2=0.5 S1OFF=1
.save V(PV1P) V(PV2P) V(PV3P) I(VsA1) I(VsB1) I(VsA2) I(VsB2) V(DA1) V(DB1) V(DA2) V(DB2) V(BETA) V(STRESS) V(RV1) V(RV2) V(IM1R) V(IM2R) I(Bload) I(Vi1) I(Vi2) I(Vi3) V(VREF2) V(HSA2) V(HSB2) V(SWA2)
.ic V(PV1P)=70 V(PV2P)=47.6 V(PV3P)=23.8
.step param D2 list 0.49 0.5 0.51
.tran 0 3m 0 250n uic
.meas tran y1 AVG V(PV1P,PV2P)-V(PV2P,PV3P) FROM 0.0025 TO 0.003
.meas tran y2 AVG V(PV2P,PV3P)-V(PV3P) FROM 0.0025 TO 0.003
.meas tran y3 AVG I(VsA1)-I(VsB1) FROM 0.0025 TO 0.003
.meas tran y4 AVG I(VsA2)-I(VsB2) FROM 0.0025 TO 0.003
.meas tran ish1 AVG I(VsA1)+I(VsB1) FROM 0.0025 TO 0.003
.meas tran ish2 AVG I(VsA2)+I(VsB2) FROM 0.0025 TO 0.003
.meas tran vm1 AVG V(PV1P,PV2P) FROM 0.0025 TO 0.003
.meas tran i1 AVG I(Vi1) FROM 0.0025 TO 0.003
.meas tran vm2 AVG V(PV2P,PV3P) FROM 0.0025 TO 0.003
.meas tran i2 AVG I(Vi2) FROM 0.0025 TO 0.003
.meas tran vm3 AVG V(PV3P) FROM 0.0025 TO 0.003
.meas tran i3 AVG I(Vi3) FROM 0.0025 TO 0.003
.meas tran vstr AVG V(PV1P) FROM 0.0025 TO 0.003
.meas tran istr AVG I(Bload) FROM 0.0025 TO 0.003
.meas tran vsa2avg AVG I(VsA2) FROM 0.0025 TO 0.003
.meas tran vsa2max MAX I(VsA2) FROM 0.00298 TO 0.003
.meas tran vsa2min MIN I(VsA2) FROM 0.00298 TO 0.003
.meas tran vsa2rms RMS I(VsA2) FROM 0.0025 TO 0.003
.meas tran vsb2avg AVG I(VsB2) FROM 0.0025 TO 0.003
.meas tran vsb2max MAX I(VsB2) FROM 0.00298 TO 0.003
.meas tran vsb2min MIN I(VsB2) FROM 0.00298 TO 0.003
.meas tran vsb2rms RMS I(VsB2) FROM 0.0025 TO 0.003
.end
