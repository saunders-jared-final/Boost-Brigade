* S9i - IDENTIFICATION of the S9 plant: open loop, baseline + 4 modal duty steps (RUN 1..5) -> G -> M (qspice_ident.py)
.lib shuffler_models.lib
Vi1 a1 PV1P 0
Xpv1 a1 PV2P E1 pvmi_150w
Dbp1 PV2P PV1P dbypass
Cpv1 PV1P PV2P 10n RSER=0.1
Vi2 a2 PV2P 0
Xpv2 a2 PV3P E2 pvmi_150w
Dbp2 PV3P PV2P dbypass
Cpv2 PV2P PV3P 10n RSER=0.1
Vi3 a3 PV3P 0
Xpv3 a3 0 E3 pvmi_150w
Dbp3 0 PV3P dbypass
Cpv3 PV3P 0 10n RSER=0.1
Bload PV1P 0 I=if(LOADSEL<0.5, V(PV1P)/Rmpp, Icc*min(1, time/200u))
Vir1 ra1 R1P 0
Xpvr1 ra1 R2P E1 pvmi_150w
Dbpr1 R2P R1P dbypass
Cpvr1 R1P R2P 10n RSER=0.1
Vir2 ra2 R2P 0
Xpvr2 ra2 R3P E2 pvmi_150w
Dbpr2 R3P R2P dbypass
Cpvr2 R2P R3P 10n RSER=0.1
Vir3 ra3 R3P 0
Xpvr3 ra3 0 E3 pvmi_150w
Dbpr3 0 R3P dbypass
Cpvr3 R3P 0 10n RSER=0.1
Bref R1P 0 I=if(LOADSEL<0.5, V(R1P)/Rmpp, Icc*min(1, time/200u))
BE1 E1 0 V=table(CASE, 1,1000, 2,1000, 3,1000)
BE2 E2 0 V=table(CASE, 1,1000, 2,600, 3,1000)
BE3 E3 0 V=table(CASE, 1,1000, 2,1000, 3,400)
C1 PV1P PV2P 130u RSER=28m
C2 PV2P PV3P 130u RSER=28m
C3 PV2P PV3P 130u RSER=28m
C4 PV3P 0 130u RSER=28m
MTA1 PV1P gTA1 SWA1 SWA1 STD45N10F7
MBA1 SWA1 gBA1 PV3P PV3P STD45N10F7
RonTA1 ohTA1 gTA1 10
RoffTA1 olTA1 gTA1 4.7
XdTA1 PWM_AH1 PWM_AL1 BOOTA1 SWA1 ohTA1 olTA1 1ED3140
RonBA1 ohBA1 gBA1 10
RoffBA1 olBA1 gBA1 4.7
XdBA1 PWM_AL1 PWM_AH1 VREG1 PV3P ohBA1 olBA1 1ED3140
MTB1 PV1P gTB1 SWB1 SWB1 STD45N10F7
MBB1 SWB1 gBB1 PV3P PV3P STD45N10F7
RonTB1 ohTB1 gTB1 10
RoffTB1 olTB1 gTB1 4.7
XdTB1 PWM_BH1 PWM_BL1 BOOTB1 SWB1 ohTB1 olTB1 1ED3140
RonBB1 ohBB1 gBB1 10
RoffBB1 olBB1 gBB1 4.7
XdBB1 PWM_BL1 PWM_BH1 VREG1 PV3P ohBB1 olBB1 1ED3140
XL1 LA2_1 LB2_1 SWB1 SWA1 ERUC23-4R1K
VsA1 LA2_1 LA2s_1 0
XsA1 LA2s_1 PV2P TMCS1126 RSH=0.7m LSH=0.5n
VsB1 LB2_1 LB2s_1 0
XsB1 LB2s_1 PV2P TMCS1126 RSH=0.7m LSH=0.5n
Vreg1 VREG1 PV3P 12
CvL1 VREG1 PV3P 100n RSER=20m
Cv2L1 VREG1 PV3P 10u RSER=5m
DbA1 bsaA1 BOOTA1 VSSA210
RbA1 bsaA1 VREG1 10
CbA1 BOOTA1 SWA1 100n RSER=20m
Cb2A1 BOOTA1 SWA1 10u RSER=5m
DbB1 bsaB1 BOOTB1 VSSA210
RbB1 bsaB1 VREG1 10
CbB1 BOOTB1 SWB1 100n RSER=20m
Cb2B1 BOOTB1 SWB1 10u RSER=5m
BpTA1 PWM_AH1 0 V=if(V(RAMPA) < V(DA1C)-0.02, 3.3, 0)
BpBA1 PWM_AL1 0 V=if(V(RAMPA) > V(DA1C), if(V(RAMPA) < 0.98, 3.3, 0), 0)
BpTB1 PWM_BH1 0 V=if(V(RAMPB) < V(DB1C)-0.02, 3.3, 0)
BpBB1 PWM_BL1 0 V=if(V(RAMPB) > V(DB1C), if(V(RAMPB) < 0.98, 3.3, 0), 0)
MTA2 PV2P gTA2 SWA2 SWA2 STD45N10F7
MBA2 SWA2 gBA2 0 0 STD45N10F7
RonTA2 ohTA2 gTA2 10
RoffTA2 olTA2 gTA2 4.7
XdTA2 PWM_AH2 PWM_AL2 BOOTA2 SWA2 ohTA2 olTA2 1ED3140
RonBA2 ohBA2 gBA2 10
RoffBA2 olBA2 gBA2 4.7
XdBA2 PWM_AL2 PWM_AH2 VREG2 0 ohBA2 olBA2 1ED3140
MTB2 PV2P gTB2 SWB2 SWB2 STD45N10F7
MBB2 SWB2 gBB2 0 0 STD45N10F7
RonTB2 ohTB2 gTB2 10
RoffTB2 olTB2 gTB2 4.7
XdTB2 PWM_BH2 PWM_BL2 BOOTB2 SWB2 ohTB2 olTB2 1ED3140
RonBB2 ohBB2 gBB2 10
RoffBB2 olBB2 gBB2 4.7
XdBB2 PWM_BL2 PWM_BH2 VREG2 0 ohBB2 olBB2 1ED3140
XL2 LA2_2 LB2_2 SWB2 SWA2 ERUC23-4R1K
VsA2 LA2_2 LA2s_2 0
XsA2 LA2s_2 PV3P TMCS1126 RSH=0.7m LSH=0.5n
VsB2 LB2_2 LB2s_2 0
XsB2 LB2s_2 PV3P TMCS1126 RSH=0.7m LSH=0.5n
Vreg2 VREG2 0 12
CvL2 VREG2 0 100n RSER=20m
Cv2L2 VREG2 0 10u RSER=5m
DbA2 bsaA2 BOOTA2 VSSA210
RbA2 bsaA2 VREG2 10
CbA2 BOOTA2 SWA2 100n RSER=20m
Cb2A2 BOOTA2 SWA2 10u RSER=5m
DbB2 bsaB2 BOOTB2 VSSA210
RbB2 bsaB2 VREG2 10
CbB2 BOOTB2 SWB2 100n RSER=20m
Cb2B2 BOOTB2 SWB2 10u RSER=5m
BpTA2 PWM_AH2 0 V=if(V(RAMPA) < V(DA2C)-0.02, 3.3, 0)
BpBA2 PWM_AL2 0 V=if(V(RAMPA) > V(DA2C), if(V(RAMPA) < 0.98, 3.3, 0), 0)
BpTB2 PWM_BH2 0 V=if(V(RAMPB) < V(DB2C)-0.02, 3.3, 0)
BpBB2 PWM_BL2 0 V=if(V(RAMPB) > V(DB2C), if(V(RAMPB) < 0.98, 3.3, 0), 0)
BhsA1 HSA1 0 V=1.65+0.1*I(VsA1)
BhsB1 HSB1 0 V=1.65+-0.025*I(VsB1)
BhsA2 HSA2 0 V=1.65+0.1*I(VsA2)
BhsB2 HSB2 0 V=1.65+-0.025*I(VsB2)
Vrampa RAMPA 0 PULSE(0 1 0 9.998e-06 1n 1n 1e-05)
Vrampb RAMPB 0 PULSE(0 1 5e-06 9.998e-06 1n 1n 1e-05)
Ven CTRL_EN 0 PWL(0 0 1 0 1 1)
Vref1 VREF1 0 PWL(0 0 0.003 0 0.003001 {VSTEP})
Vref2 VREF2 0 0
BdDA1 DA1C 0 V=if(V(CTRL_EN)>0.5, V(DA1), 0.5+table(RUN, 1,0, 2,DU/2, 3,0, 4,DU/2, 5,0))
BdDB1 DB1C 0 V=if(V(CTRL_EN)>0.5, V(DB1), 0.5+table(RUN, 1,0, 2,DU/2, 3,0, 4,-DU/2, 5,0))
BdDA2 DA2C 0 V=if(V(CTRL_EN)>0.5, V(DA2), 0.5+table(RUN, 1,0, 2,0, 3,DU/2, 4,0, 5,DU/2))
BdDB2 DB2C 0 V=if(V(CTRL_EN)>0.5, V(DB2), 0.5+table(RUN, 1,0, 2,0, 3,DU/2, 4,0, 5,-DU/2))
Ø´Xc «PV1P´d PV2P´d PV3P´d HSA1´d HSB1´d HSA2´d HSB2´d CTRL_EN´d VREF1´d VREF2´d» «DA1´d DB1´d DA2´d DB2´d RV1´d RV2´d BETA´d STRESS´d IM1R´d IM2R´d» «0»  shuffler_ctrl_dll Rout=1 Cout=1p
.param Rmpp=6.682 Icc=6.5 CASE=2 LOADSEL=1 VSTEP=0 DU=0.04 RUN=1
.step param RUN list 1 2 3 4 5
.tran 0 4m 2.5m 250n
.meas tran y1 AVG V(PV1P,PV2P)-V(PV2P,PV3P) FROM 0.5m TO 1.5m
.meas tran y2 AVG V(PV2P,PV3P)-V(PV3P) FROM 0.5m TO 1.5m
.meas tran y3 AVG I(VsA1)-I(VsB1) FROM 0.5m TO 1.5m
.meas tran y4 AVG I(VsA2)-I(VsB2) FROM 0.5m TO 1.5m
.meas tran ish1 AVG I(VsA1)+I(VsB1) FROM 0.5m TO 1.5m
.meas tran ish2 AVG I(VsA2)+I(VsB2) FROM 0.5m TO 1.5m
.meas tran pout AVG V(PV1P)*I(Bload) FROM 0.5m TO 1.5m
.end
