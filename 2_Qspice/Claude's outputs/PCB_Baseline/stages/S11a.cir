* S11a - EDGE CALIBRATION (7 Oct): NGE103 27 V on the bottom input only, shuffler 2 at 50 % 100 kHz, output open
.lib shuffler_models.lib
Xcab1p m1p PV1P trace R=0.00695 L={LLEAD} RP=50
Xcab1n m1n PV2P trace R=0.00695 L={LLEAD} RP=50
Vi1 a1 m1p 0
Xpv1 a1 m1n E1 nge_ch VS=1k
Dbp1 m1n m1p dbypass
Cpv1 m1p m1n 10n RSER=0.1 IC=0
Xcab2p m2p PV2P trace R=0.00695 L={LLEAD} RP=50
Xcab2n m2n PV3P trace R=0.00695 L={LLEAD} RP=50
Vi2 a2 m2p 0
Xpv2 a2 m2n E2 nge_ch VS=1k
Dbp2 m2n m2p dbypass
Cpv2 m2p m2n 10n RSER=0.1 IC=27
Xcab3p m3p PV3P trace R=0.00695 L={LLEAD} RP=50
Xcab3n m3n 0 trace R=0.00695 L={LLEAD} RP=50
Vi3 a3 m3p 0
Xpv3 a3 m3n E3 nge_ch VS=27
Dbp3 m3n m3p dbypass
Cpv3 m3p m3n 10n RSER=0.1 IC=27
Bload PV1P 0 I=if(LOADSEL<0.5, V(PV1P)/Rmpp, if(LOADSEL<1.5, Icc*min(1, time/200u), max(V(PV1P)-VCV,0)/RCV))
BE1 E1 0 V=ILIM1*1000
BE2 E2 0 V=ILIM2*1000
BE3 E3 0 V=1000*if(time<TSHADE, ILIM3, ILIM3*SHADE)
C1 PV1P c1n 130u RSER={KESR*0.028} IC=0
Lc1 c1n PV2P {KESL*1.5e-08} RPAR=5
C2 PV2P c2n 130u RSER={KESR*0.028} IC=27
Lc2 c2n PV3P {KESL*1.5e-08} RPAR=5
C3 PV2P c3n 130u RSER={KESR*0.028} IC=27
Lc3 c3n PV3P {KESL*1.5e-08} RPAR=5
C4 PV3P c4n 130u RSER={KESR*0.028} IC=27
Lc4 c4n 0 {KESL*1.5e-08} RPAR=5
XtT1 PV1P T1 trace R={KR*0.000518} L={KLRAIL*2.4e-09}
XtB1 PV3P B1 trace R={KR*0.00011} L={KLRAIL*2.3e-10}
LdTA1 T1 dTA1 {KLSW*1.5e-09} RPAR=5
LsTA1 sTA1 SWA1 {KLSW*3e-09} RPAR=5
LdBA1 SWA1 dBA1 {KLSW*1.5e-09} RPAR=5
LsBA1 sBA1 B1 {KLSW*3e-09} RPAR=5
MTA1 dTA1 gTA1 sTA1 sTA1 STD45N10F7
MBA1 dBA1 gBA1 sBA1 sBA1 STD45N10F7
XtgTA1 giTA1 gTA1 trace R=5.61m L=1.19n
RonTA1 ohTA1 giTA1 10
RoffTA1 olTA1 giTA1 4.7
XdTA1 PWM_AH1 PWM_AL1 BOOTA1 SWA1 ohTA1 olTA1 1ED3140
XtgBA1 giBA1 gBA1 trace R=10.8m L=1.41n
RonBA1 ohBA1 giBA1 10
RoffBA1 olBA1 giBA1 4.7
XdBA1 PWM_AL1 PWM_AH1 VREG1 B1 ohBA1 olBA1 1ED3140
RsnTA1 dTA1 snTA1 {Rsn}
CsnTA1 snTA1 sTA1 {Csn}
RsnBA1 dBA1 snBA1 {Rsn}
CsnBA1 snBA1 sBA1 {Csn}
LdTB1 T1 dTB1 {KLSW*1.5e-09} RPAR=5
LsTB1 sTB1 SWB1 {KLSW*3e-09} RPAR=5
LdBB1 SWB1 dBB1 {KLSW*1.5e-09} RPAR=5
LsBB1 sBB1 B1 {KLSW*3e-09} RPAR=5
MTB1 dTB1 gTB1 sTB1 sTB1 STD45N10F7
MBB1 dBB1 gBB1 sBB1 sBB1 STD45N10F7
XtgTB1 giTB1 gTB1 trace R=3.61m L=1.04n
RonTB1 ohTB1 giTB1 10
RoffTB1 olTB1 giTB1 4.7
XdTB1 PWM_BH1 PWM_BL1 BOOTB1 SWB1 ohTB1 olTB1 1ED3140
XtgBB1 giBB1 gBB1 trace R=5.33m L=1.25n
RonBB1 ohBB1 giBB1 10
RoffBB1 olBB1 giBB1 4.7
XdBB1 PWM_BL1 PWM_BH1 VREG1 B1 ohBB1 olBB1 1ED3140
RsnTB1 dTB1 snTB1 {Rsn}
CsnTB1 snTB1 sTB1 {Csn}
RsnBB1 dBB1 snBB1 {Rsn}
CsnBB1 snBB1 sBB1 {Csn}
XtSWA1 SWA1 SWAL1 trace R={KR*0.000795} L={KLSW*1.58e-09}
XtSWB1 SWBL1 SWB1 trace R={KR*0.001563} L={KLSW*5.58e-09}
XL1 LA2_1 LB2_1 SWBL1 SWAL1 ERUC23-4R1K
VsA1 LA2_1 LA2s_1 0
XtLA1 LA2s_1 LA2t_1 trace R={KR*0.001352} L={KLSW*2.68e-09}
XsA1 LA2t_1 M1 TMCS1126 RSH=0.7m LSH=0.5n
VsB1 LB2_1 LB2s_1 0
XtLB1 LB2s_1 LB2t_1 trace R={KR*0.000992} L={KLSW*2.32e-09}
XsB1 LB2t_1 M1 TMCS1126 RSH=0.7m LSH=0.5n
XtM1 M1 PV2P trace R={KR*0.000149} L={KLRAIL*2.9e-10}
Vreg1 VREG1 B1 12
CvL1 VREG1 B1 100n RSER=20m
Cv2L1 VREG1 B1 10u RSER=5m
DbA1 bsaA1 BOOTA1 VSSA210
RbA1 bsaA1 VREG1 10
CbA1 BOOTA1 SWA1 100n RSER=20m IC=11.5
Cb2A1 BOOTA1 SWA1 10u RSER=5m IC=11.5
DbB1 bsaB1 BOOTB1 VSSA210
RbB1 bsaB1 VREG1 10
CbB1 BOOTB1 SWB1 100n RSER=20m IC=11.5
Cb2B1 BOOTB1 SWB1 10u RSER=5m IC=11.5
BpTA1 PWM_AH1 0 V=if(S1OFF>0.5, 0, if(V(RAMPA) < V(DA1C)-0.02, 3.3, 0))
BpBA1 PWM_AL1 0 V=if(S1OFF>0.5, 0, if(V(RAMPA) > V(DA1C), if(V(RAMPA) < 0.98, 3.3, 0), 0))
BpTB1 PWM_BH1 0 V=if(S1OFF>0.5, 0, if(V(RAMPB) < V(DB1C)-0.02, 3.3, 0))
BpBB1 PWM_BL1 0 V=if(S1OFF>0.5, 0, if(V(RAMPB) > V(DB1C), if(V(RAMPB) < 0.98, 3.3, 0), 0))
Chf01 T1 hf01 {Chf} RSER={KHF*0.02}
Lhf01 hf01 B1 {KHF*8e-10}
Chf11 T1 hf11 {Chf} RSER={KHF*0.02}
Lhf11 hf11 B1 {KHF*8e-10}
XtT2 PV2P T2 trace R={KR*0.000149} L={KLRAIL*2.9e-10}
XtB2 0 B2 trace R={KR*2.2e-05} L={KLRAIL*2e-11}
LdTA2 T2 dTA2 {KLSW*1.5e-09} RPAR=5
LsTA2 sTA2 SWA2 {KLSW*3e-09} RPAR=5
LdBA2 SWA2 dBA2 {KLSW*1.5e-09} RPAR=5
LsBA2 sBA2 B2 {KLSW*3e-09} RPAR=5
MTA2 dTA2 gTA2 sTA2 sTA2 STD45N10F7
MBA2 dBA2 gBA2 sBA2 sBA2 STD45N10F7
XtgTA2 giTA2 gTA2 trace R=3.01m L=0.91n
RonTA2 ohTA2 giTA2 10
RoffTA2 olTA2 giTA2 4.7
XdTA2 PWM_AH2 PWM_AL2 BOOTA2 SWA2 ohTA2 olTA2 1ED3140
XtgBA2 giBA2 gBA2 trace R=4.85m L=1.25n
RonBA2 ohBA2 giBA2 10
RoffBA2 olBA2 giBA2 4.7
XdBA2 PWM_AL2 PWM_AH2 VREG2 B2 ohBA2 olBA2 1ED3140
RsnTA2 dTA2 snTA2 {Rsn}
CsnTA2 snTA2 sTA2 {Csn}
RsnBA2 dBA2 snBA2 {Rsn}
CsnBA2 snBA2 sBA2 {Csn}
LdTB2 T2 dTB2 {KLSW*1.5e-09} RPAR=5
LsTB2 sTB2 SWB2 {KLSW*3e-09} RPAR=5
LdBB2 SWB2 dBB2 {KLSW*1.5e-09} RPAR=5
LsBB2 sBB2 B2 {KLSW*3e-09} RPAR=5
MTB2 dTB2 gTB2 sTB2 sTB2 STD45N10F7
MBB2 dBB2 gBB2 sBB2 sBB2 STD45N10F7
XtgTB2 giTB2 gTB2 trace R=3.39m L=0.95n
RonTB2 ohTB2 giTB2 10
RoffTB2 olTB2 giTB2 4.7
XdTB2 PWM_BH2 PWM_BL2 BOOTB2 SWB2 ohTB2 olTB2 1ED3140
XtgBB2 giBB2 gBB2 trace R=4.44m L=1.1n
RonBB2 ohBB2 giBB2 10
RoffBB2 olBB2 giBB2 4.7
XdBB2 PWM_BL2 PWM_BH2 VREG2 B2 ohBB2 olBB2 1ED3140
RsnTB2 dTB2 snTB2 {Rsn}
CsnTB2 snTB2 sTB2 {Csn}
RsnBB2 dBB2 snBB2 {Rsn}
CsnBB2 snBB2 sBB2 {Csn}
XtSWA2 SWA2 SWAL2 trace R={KR*0.001872} L={KLSW*2.52e-09}
XtSWB2 SWBL2 SWB2 trace R={KR*0.001132} L={KLSW*1.04e-09}
XL2 LA2_2 LB2_2 SWBL2 SWAL2 ERUC23-4R1K
VsA2 LA2_2 LA2s_2 0
XtLA2 LA2s_2 LA2t_2 trace R={KR*0.001} L={KLSW*2e-09}
XsA2 LA2t_2 M2 TMCS1126 RSH=0.7m LSH=0.5n
VsB2 LB2_2 LB2s_2 0
XtLB2 LB2s_2 LB2t_2 trace R={KR*0.001} L={KLSW*2e-09}
XsB2 LB2t_2 M2 TMCS1126 RSH=0.7m LSH=0.5n
XtM2 M2 PV3P trace R={KR*0.00011} L={KLRAIL*2.3e-10}
Vreg2 VREG2 B2 12
CvL2 VREG2 B2 100n RSER=20m
Cv2L2 VREG2 B2 10u RSER=5m
DbA2 bsaA2 BOOTA2 VSSA210
RbA2 bsaA2 VREG2 10
CbA2 BOOTA2 SWA2 100n RSER=20m IC=11.5
Cb2A2 BOOTA2 SWA2 10u RSER=5m IC=11.5
DbB2 bsaB2 BOOTB2 VSSA210
RbB2 bsaB2 VREG2 10
CbB2 BOOTB2 SWB2 100n RSER=20m IC=11.5
Cb2B2 BOOTB2 SWB2 10u RSER=5m IC=11.5
BpTA2 PWM_AH2 0 V=if(V(RAMPA) < V(DA2C)-0.02, 3.3, 0)
BpBA2 PWM_AL2 0 V=if(V(RAMPA) > V(DA2C), if(V(RAMPA) < 0.98, 3.3, 0), 0)
BpTB2 PWM_BH2 0 V=if(V(RAMPB) < V(DB2C)-0.02, 3.3, 0)
BpBB2 PWM_BL2 0 V=if(V(RAMPB) > V(DB2C), if(V(RAMPB) < 0.98, 3.3, 0), 0)
Chf02 T2 hf02 {Chf} RSER={KHF*0.02}
Lhf02 hf02 B2 {KHF*8e-10}
Chf12 T2 hf12 {Chf} RSER={KHF*0.02}
Lhf12 hf12 B2 {KHF*8e-10}
BhsA1 HSA1R 0 V=1.65+0.1*I(VsA1)
RhsA1 HSA1R HSA1 1k
ChsA1 HSA1 0 3.183e-10
BhsB1 HSB1R 0 V=1.65+-0.025*I(VsB1)
RhsB1 HSB1R HSB1 1k
ChsB1 HSB1 0 3.183e-10
BhsA2 HSA2R 0 V=1.65+0.1*I(VsA2)
RhsA2 HSA2R HSA2 1k
ChsA2 HSA2 0 3.183e-10
BhsB2 HSB2R 0 V=1.65+-0.025*I(VsB2)
RhsB2 HSB2R HSB2 1k
ChsB2 HSB2 0 3.183e-10
Vrampa RAMPA 0 PULSE(0 1 0 9.998e-06 1n 1n 1e-05)
Vrampb RAMPB 0 PULSE(0 1 5e-06 9.998e-06 1n 1n 1e-05)
Ven CTRL_EN 0 PWL(0 0 1 0 1 1)
Vref1 VREF1 0 0
Vref2 VREF2 0 PWL(0 0 0.002 0 0.002001 {VSTEP2})
BdDA1 DA1C 0 V=if(V(CTRL_EN)>0.5, V(DA1), 0.5+table(RUN, 1,0, 2,DU/2, 3,0, 4,DU/2, 5,0))
BdDB1 DB1C 0 V=if(V(CTRL_EN)>0.5, V(DB1), 0.5+table(RUN, 1,0, 2,DU/2, 3,0, 4,-DU/2, 5,0))
BdDA2 DA2C 0 V=if(V(CTRL_EN)>0.5, V(DA2), 0.5+table(RUN, 1,0, 2,0, 3,DU/2, 4,0, 5,DU/2))
BdDB2 DB2C 0 V=if(V(CTRL_EN)>0.5, V(DB2), 0.5+table(RUN, 1,0, 2,0, 3,DU/2, 4,0, 5,-DU/2))
BtKSCALE KSCALE 0 V=KSCALE
BtMSEL MSEL 0 V=MSEL
BtFILT FILT 0 V=FILT
BtFC FC 0 V=FC
BtNOISE NOISE 0 V=NOISE
BtSAMP SAMP 0 V=SAMP
BtKBERR KBERR 0 V=KBERR
BtFSWP FSWP 0 V=100000
BtVM1SRC VM1SRC 0 V=VM1SRC
BtVSTRP VSTRP 0 V=VSTRP
Ø´Xc «PV1P´d PV2P´d PV3P´d HSA1´d HSB1´d HSA2´d HSB2´d CTRL_EN´d VREF1´d VREF2´d KSCALE´d MSEL´d FILT´d FC´d NOISE´d SAMP´d KBERR´d FSWP´d VM1SRC´d VSTRP´d» «DA1´d DB1´d DA2´d DB2´d RV1´d RV2´d BETA´d STRESS´d IM1R´d IM2R´d» «0»  shuffler_ctrl_dll2 Rout=1 Cout=1p
.param LOADSEL=1 VCV=70 RCV=0.05 Rmpp=1 Icc=0 VSET=25 RCLAMP=0.05 ILIM1=0
.param ILIM2=0 ILIM3=3 IRR3=1000 SHADE=0.5 TSHADE=1 KSCALE=1 MSEL=0 FILT=0
.param FC=2000 NOISE=0 SAMP=1 KBERR=1 VM1SRC=0 VSTRP=70 VSTEP2=2 DU=0
.param RUN=1 D2=0.5 S1OFF=1 KLSW=1 KLRAIL=1 KESL=1 KESR=1 KHF=1
.param KR=1 LLEAD=750n Csn=470p Rsn=4.7 Chf=100n
.save V(PV1P) V(PV2P) V(PV3P) V(SWA1) V(SWB1) V(SWA2) V(SWB2) I(VsA2) I(VsB2) I(VsA1) I(VsB1)
.ic V(PV1P)=54 V(PV2P)=54 V(PV3P)=27
.tran 0 200u 170u 1n uic
.end
