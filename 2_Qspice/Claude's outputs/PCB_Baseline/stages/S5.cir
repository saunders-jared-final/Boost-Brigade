* S5 - 1ED3140 drivers with 10R/4R7 gate paths, 12 V rails, bootstrap supplies
.lib shuffler_models.lib
Vi1 a1 PV1P 0
Xpv1 a1 PV2P E1 pvmi_aiko
Dbp1 PV2P PV1P dbypass
Cpv1 PV1P PV2P 10n RSER=0.1
Vi2 a2 PV2P 0
Xpv2 a2 PV3P E2 pvmi_aiko
Dbp2 PV3P PV2P dbypass
Cpv2 PV2P PV3P 10n RSER=0.1
Vi3 a3 PV3P 0
Xpv3 a3 0 E3 pvmi_aiko
Dbp3 0 PV3P dbypass
Cpv3 PV3P 0 10n RSER=0.1
Bload PV1P 0 I=if(LOADSEL<0.5, V(PV1P)/Rmpp, Icc*min(1, time/200u))
Vir1 ra1 R1P 0
Xpvr1 ra1 R2P E1 pvmi_aiko
Dbpr1 R2P R1P dbypass
Cpvr1 R1P R2P 10n RSER=0.1
Vir2 ra2 R2P 0
Xpvr2 ra2 R3P E2 pvmi_aiko
Dbpr2 R3P R2P dbypass
Cpvr2 R2P R3P 10n RSER=0.1
Vir3 ra3 R3P 0
Xpvr3 ra3 0 E3 pvmi_aiko
Dbpr3 0 R3P dbypass
Cpvr3 R3P 0 10n RSER=0.1
Bref R1P 0 I=if(LOADSEL<0.5, V(R1P)/Rmpp, Icc*min(1, time/200u))
BE1 E1 0 V=table(CASE, 1,1000, 2,1000, 3,1000)
BE2 E2 0 V=table(CASE, 1,1000, 2,600, 3,1000)
BE3 E3 0 V=table(CASE, 1,1000, 2,1000, 3,400)
C1 PV1P PV2P 130u RSER=28m
C2 PV2P PV3P 130u RSER=28m
C3 PV2P PV3P 130u RSER=28m
C4 PV3P 0 130u RSER=28m
MTA1 PV1P gTA1 SWA1 SWA1 STD45N10F7
MBA1 SWA1 gBA1 PV3P PV3P STD45N10F7
RonTA1 ohTA1 gTA1 10
RoffTA1 olTA1 gTA1 4.7
XdTA1 PWM_AH1 PWM_AL1 BOOTA1 SWA1 ohTA1 olTA1 1ED3140
RonBA1 ohBA1 gBA1 10
RoffBA1 olBA1 gBA1 4.7
XdBA1 PWM_AL1 PWM_AH1 VREG1 PV3P ohBA1 olBA1 1ED3140
MTB1 PV1P gTB1 SWB1 SWB1 STD45N10F7
MBB1 SWB1 gBB1 PV3P PV3P STD45N10F7
RonTB1 ohTB1 gTB1 10
RoffTB1 olTB1 gTB1 4.7
XdTB1 PWM_BH1 PWM_BL1 BOOTB1 SWB1 ohTB1 olTB1 1ED3140
RonBB1 ohBB1 gBB1 10
RoffBB1 olBB1 gBB1 4.7
XdBB1 PWM_BL1 PWM_BH1 VREG1 PV3P ohBB1 olBB1 1ED3140
XL1 LA2_1 LB2_1 SWB1 SWA1 ERUC23-4R1K
VsA1 LA2_1 LA2s_1 0
XsA1 LA2s_1 PV2P TMCS1126 RSH=0.7m LSH=0.5n
VsB1 LB2_1 LB2s_1 0
XsB1 LB2s_1 PV2P TMCS1126 RSH=0.7m LSH=0.5n
Vreg1 VREG1 PV3P 12
CvL1 VREG1 PV3P 100n RSER=20m
Cv2L1 VREG1 PV3P 10u RSER=5m
DbA1 bsaA1 BOOTA1 VSSA210
RbA1 bsaA1 VREG1 10
CbA1 BOOTA1 SWA1 100n RSER=20m
Cb2A1 BOOTA1 SWA1 10u RSER=5m
DbB1 bsaB1 BOOTB1 VSSA210
RbB1 bsaB1 VREG1 10
CbB1 BOOTB1 SWB1 100n RSER=20m
Cb2B1 BOOTB1 SWB1 10u RSER=5m
VpTA1 PWM_AH1 0 PULSE(0 3.3 0.000e+00 5n 5n 2.300e-06 5.000e-06)
VpBA1 PWM_AL1 0 PULSE(0 3.3 2.500e-06 5n 5n 2.300e-06 5.000e-06)
VpTB1 PWM_BH1 0 PULSE(0 3.3 2.500e-06 5n 5n 2.300e-06 5.000e-06)
VpBB1 PWM_BL1 0 PULSE(0 3.3 5.000e-06 5n 5n 2.300e-06 5.000e-06)
MTA2 PV2P gTA2 SWA2 SWA2 STD45N10F7
MBA2 SWA2 gBA2 0 0 STD45N10F7
RonTA2 ohTA2 gTA2 10
RoffTA2 olTA2 gTA2 4.7
XdTA2 PWM_AH2 PWM_AL2 BOOTA2 SWA2 ohTA2 olTA2 1ED3140
RonBA2 ohBA2 gBA2 10
RoffBA2 olBA2 gBA2 4.7
XdBA2 PWM_AL2 PWM_AH2 VREG2 0 ohBA2 olBA2 1ED3140
MTB2 PV2P gTB2 SWB2 SWB2 STD45N10F7
MBB2 SWB2 gBB2 0 0 STD45N10F7
RonTB2 ohTB2 gTB2 10
RoffTB2 olTB2 gTB2 4.7
XdTB2 PWM_BH2 PWM_BL2 BOOTB2 SWB2 ohTB2 olTB2 1ED3140
RonBB2 ohBB2 gBB2 10
RoffBB2 olBB2 gBB2 4.7
XdBB2 PWM_BL2 PWM_BH2 VREG2 0 ohBB2 olBB2 1ED3140
XL2 LA2_2 LB2_2 SWB2 SWA2 ERUC23-4R1K
VsA2 LA2_2 LA2s_2 0
XsA2 LA2s_2 PV3P TMCS1126 RSH=0.7m LSH=0.5n
VsB2 LB2_2 LB2s_2 0
XsB2 LB2s_2 PV3P TMCS1126 RSH=0.7m LSH=0.5n
Vreg2 VREG2 0 12
CvL2 VREG2 0 100n RSER=20m
Cv2L2 VREG2 0 10u RSER=5m
DbA2 bsaA2 BOOTA2 VSSA210
RbA2 bsaA2 VREG2 10
CbA2 BOOTA2 SWA2 100n RSER=20m
Cb2A2 BOOTA2 SWA2 10u RSER=5m
DbB2 bsaB2 BOOTB2 VSSA210
RbB2 bsaB2 VREG2 10
CbB2 BOOTB2 SWB2 100n RSER=20m
Cb2B2 BOOTB2 SWB2 10u RSER=5m
VpTA2 PWM_AH2 0 PULSE(0 3.3 0.000e+00 5n 5n 2.300e-06 5.000e-06)
VpBA2 PWM_AL2 0 PULSE(0 3.3 2.500e-06 5n 5n 2.300e-06 5.000e-06)
VpTB2 PWM_BH2 0 PULSE(0 3.3 2.500e-06 5n 5n 2.300e-06 5.000e-06)
VpBB2 PWM_BL2 0 PULSE(0 3.3 5.000e-06 5n 5n 2.300e-06 5.000e-06)
.param Rmpp=8.148 Icc=10 CASE=1 LOADSEL=0
.option savepowers
.tran 0 0.0025 0.0024 2e-08
.step param CASE list 1 2 3
.step param LOADSEL list 0 1
.meas tran vstr AVG V(PV1P)
.meas tran istr AVG I(Bload)
.meas tran pout AVG V(PV1P)*I(Bload)
.meas tran pref AVG V(R1P)*I(Bref)
.meas tran v1 AVG V(PV1P,PV2P)
.meas tran i1 AVG I(Vi1)
.meas tran p1 AVG V(PV1P,PV2P)*I(Vi1)
.meas tran v2 AVG V(PV2P,PV3P)
.meas tran i2 AVG I(Vi2)
.meas tran p2 AVG V(PV2P,PV3P)*I(Vi2)
.meas tran v3 AVG V(PV3P)
.meas tran i3 AVG I(Vi3)
.meas tran p3 AVG V(PV3P)*I(Vi3)
.meas tran vr1 AVG V(R1P,R2P)
.meas tran ir1 AVG I(Vir1)
.meas tran vr2 AVG V(R2P,R3P)
.meas tran ir2 AVG I(Vir2)
.meas tran vr3 AVG V(R3P)
.meas tran ir3 AVG I(Vir3)
.meas tran ila1 AVG I(VsA1)
.meas tran ilb1 AVG I(VsB1)
.meas tran ilapp1 PP I(VsA1)
.meas tran ish1 AVG I(VsA1)+I(VsB1)
.meas tran vswamax1 MAX V(SWA1,PV3P)
.meas tran vswamin1 MIN V(SWA1,PV3P)
.meas tran vswbmax1 MAX V(SWB1,PV3P)
.meas tran pmta1 AVG P(MTA1)
.meas tran pmba1 AVG P(MBA1)
.meas tran pmtb1 AVG P(MTB1)
.meas tran pmbb1 AVG P(MBB1)
.meas tran pconv1 AVG P(MTA1)+P(MBA1)+P(MTB1)+P(MBB1)
.meas tran vgta1 MAX V(gTA1,SWA1)
.meas tran vgtamin1 MIN V(gTA1,SWA1)
.meas tran vboota1 MIN V(BOOTA1,SWA1)
.meas tran tdead1 TRIG V(gBA1,PV3P)=6 FALL=1 TARG V(gTA1,SWA1)=6 RISE=2
.meas tran ila2 AVG I(VsA2)
.meas tran ilb2 AVG I(VsB2)
.meas tran ilapp2 PP I(VsA2)
.meas tran ish2 AVG I(VsA2)+I(VsB2)
.meas tran vswamax2 MAX V(SWA2,GND)
.meas tran vswamin2 MIN V(SWA2,GND)
.meas tran vswbmax2 MAX V(SWB2,GND)
.meas tran pmta2 AVG P(MTA2)
.meas tran pmba2 AVG P(MBA2)
.meas tran pmtb2 AVG P(MTB2)
.meas tran pmbb2 AVG P(MBB2)
.meas tran pconv2 AVG P(MTA2)+P(MBA2)+P(MTB2)+P(MBB2)
.meas tran vgta2 MAX V(gTA2,SWA2)
.meas tran vgtamin2 MIN V(gTA2,SWA2)
.meas tran vboota2 MIN V(BOOTA2,SWA2)
.meas tran tdead2 TRIG V(gBA2,GND)=6 FALL=1 TARG V(gTA2,SWA2)=6 RISE=2
.end
