* S9.qsch
Vi1 N25 PV1P 0
Xpv1 N25 PV2P E1 pvmi_150w
Dbp1 PV2P PV1P dbypass
Cpv1 PV1P PV2P 10n RSER=0.1
Vi2 N26 PV2P 0
Xpv2 N26 PV3P E2 pvmi_150w
Dbp2 PV3P PV2P dbypass
Cpv2 PV2P PV3P 10n RSER=0.1
Vi3 N27 PV3P 0
Xpv3 N27 0 E3 pvmi_150w
Dbp3 0 PV3P dbypass
Cpv3 PV3P 0 10n RSER=0.1
Bload PV1P 0 I=if(LOADSEL<0.5, V(PV1P)/Rmpp, Icc*min(1, time/200u))
Vir1 N28 R1P 0
Xpvr1 N28 R2P E1 pvmi_150w
Dbpr1 R2P R1P dbypass
Cpvr1 R1P R2P 10n RSER=0.1
Vir2 N29 R2P 0
Xpvr2 N29 R3P E2 pvmi_150w
Dbpr2 R3P R2P dbypass
Cpvr2 R2P R3P 10n RSER=0.1
Vir3 N30 R3P 0
Xpvr3 N30 0 E3 pvmi_150w
Dbpr3 0 R3P dbypass
Cpvr3 R3P 0 10n RSER=0.1
Bref R1P 0 I=if(LOADSEL<0.5, V(R1P)/Rmpp, Icc*min(1, time/200u))
BE1 E1 0 V=table(CASE, 1,1000, 2,1000, 3,1000)
BE2 E2 0 V=table(CASE, 1,1000, 2,600, 3,1000)
BE3 E3 0 V=table(CASE, 1,1000, 2,1000, 3,400)
C1 PV1P PV2P 130u RSER=28m
C2 PV2P PV3P 130u RSER=28m
C3 PV2P PV3P 130u RSER=28m
C4 PV3P 0 130u RSER=28m
MTA1 PV1P N01 SWA1 SWA1 STD45N10F7 NMOS
MBA1 SWA1 N04 PV3P PV3P STD45N10F7 NMOS
RonTA1 N02 N01 10
RoffTA1 N03 N01 4.7
XdTA1 PWM_AH1 PWM_AL1 BOOTA1 SWA1 N02 N03 1ED3140
RonBA1 N05 N04 10
RoffBA1 N06 N04 4.7
XdBA1 PWM_AL1 PWM_AH1 VREG1 PV3P N05 N06 1ED3140
MTB1 PV1P N07 SWB1 SWB1 STD45N10F7 NMOS
MBB1 SWB1 N10 PV3P PV3P STD45N10F7 NMOS
RonTB1 N08 N07 10
RoffTB1 N09 N07 4.7
XdTB1 PWM_BH1 PWM_BL1 BOOTB1 SWB1 N08 N09 1ED3140
RonBB1 N11 N10 10
RoffBB1 N12 N10 4.7
XdBB1 PWM_BL1 PWM_BH1 VREG1 PV3P N11 N12 1ED3140
XL1 N31 N32 SWB1 SWA1 ERUC23-4R1K
VsA1 N31 N33 0
XsA1 N33 PV2P TMCS1126 RSH=0.7m LSH=0.5n
VsB1 N32 N34 0
XsB1 N34 PV2P TMCS1126 RSH=0.7m LSH=0.5n
Vreg1 VREG1 PV3P 12
CvL1 VREG1 PV3P 100n RSER=20m
Cv2L1 VREG1 PV3P 10u RSER=5m
DbA1 N35 BOOTA1 VSSA210
RbA1 N35 VREG1 10
CbA1 BOOTA1 SWA1 100n RSER=20m
Cb2A1 BOOTA1 SWA1 10u RSER=5m
DbB1 N36 BOOTB1 VSSA210
RbB1 N36 VREG1 10
CbB1 BOOTB1 SWB1 100n RSER=20m
Cb2B1 BOOTB1 SWB1 10u RSER=5m
BpTA1 PWM_AH1 0 V=if(V(RAMPA) < V(DA1)-0.02, 3.3, 0)
BpBA1 PWM_AL1 0 V=if(V(RAMPA) > V(DA1), if(V(RAMPA) < 0.98, 3.3, 0), 0)
BpTB1 PWM_BH1 0 V=if(V(RAMPB) < V(DB1)-0.02, 3.3, 0)
BpBB1 PWM_BL1 0 V=if(V(RAMPB) > V(DB1), if(V(RAMPB) < 0.98, 3.3, 0), 0)
MTA2 PV2P N13 SWA2 SWA2 STD45N10F7 NMOS
MBA2 SWA2 N16 0 0 STD45N10F7 NMOS
RonTA2 N14 N13 10
RoffTA2 N15 N13 4.7
XdTA2 PWM_AH2 PWM_AL2 BOOTA2 SWA2 N14 N15 1ED3140
RonBA2 N17 N16 10
RoffBA2 N18 N16 4.7
XdBA2 PWM_AL2 PWM_AH2 VREG2 0 N17 N18 1ED3140
MTB2 PV2P N19 SWB2 SWB2 STD45N10F7 NMOS
MBB2 SWB2 N22 0 0 STD45N10F7 NMOS
RonTB2 N20 N19 10
RoffTB2 N21 N19 4.7
XdTB2 PWM_BH2 PWM_BL2 BOOTB2 SWB2 N20 N21 1ED3140
RonBB2 N23 N22 10
RoffBB2 N24 N22 4.7
XdBB2 PWM_BL2 PWM_BH2 VREG2 0 N23 N24 1ED3140
XL2 N37 N38 SWB2 SWA2 ERUC23-4R1K
VsA2 N37 N39 0
XsA2 N39 PV3P TMCS1126 RSH=0.7m LSH=0.5n
VsB2 N38 N40 0
XsB2 N40 PV3P TMCS1126 RSH=0.7m LSH=0.5n
Vreg2 VREG2 0 12
CvL2 VREG2 0 100n RSER=20m
Cv2L2 VREG2 0 10u RSER=5m
DbA2 N41 BOOTA2 VSSA210
RbA2 N41 VREG2 10
CbA2 BOOTA2 SWA2 100n RSER=20m
Cb2A2 BOOTA2 SWA2 10u RSER=5m
DbB2 N42 BOOTB2 VSSA210
RbB2 N42 VREG2 10
CbB2 BOOTB2 SWB2 100n RSER=20m
Cb2B2 BOOTB2 SWB2 10u RSER=5m
BpTA2 PWM_AH2 0 V=if(V(RAMPA) < V(DA2)-0.02, 3.3, 0)
BpBA2 PWM_AL2 0 V=if(V(RAMPA) > V(DA2), if(V(RAMPA) < 0.98, 3.3, 0), 0)
BpTB2 PWM_BH2 0 V=if(V(RAMPB) < V(DB2)-0.02, 3.3, 0)
BpBB2 PWM_BL2 0 V=if(V(RAMPB) > V(DB2), if(V(RAMPB) < 0.98, 3.3, 0), 0)
BhsA1 HSA1 0 V=1.65+0.1*I(VsA1)
BhsB1 HSB1 0 V=1.65+-0.025*I(VsB1)
BhsA2 HSA2 0 V=1.65+0.1*I(VsA2)
BhsB2 HSB2 0 V=1.65+-0.025*I(VsB2)
Vrampa RAMPA 0 PULSE(0 1 0 9.998e-06 1n 1n 1e-05)
Vrampb RAMPB 0 PULSE(0 1 5e-06 9.998e-06 1n 1n 1e-05)
Ven CTRL_EN 0 PWL(0 0 0.0005 0 0.000501 1)
Vref1 VREF1 0 PWL(0 0 0.003 0 0.003001 {VSTEP})
Vref2 VREF2 0 0
Ø´Xc «PV1P´d PV2P´d PV3P´d HSA1´d HSB1´d HSA2´d HSB2´d CTRL_EN´d VREF1´d VREF2´d» «DA1´d DB1´d DA2´d DB2´d RV1´d RV2´d BETA´d STRESS´d IM1R´d IM2R´d» «0»  shuffler_ctrl_dll Rout=1 Cout=1p
.param Rmpp=6.682 Icc=8 CASE=2 LOADSEL=1 VSTEP=1
.tran 0 6m 0 250n
.meas tran vd1 AVG V(PV1P,PV2P) FROM 0.002 TO 0.0029
.meas tran vd2 AVG V(PV2P,PV3P) FROM 0.002 TO 0.0029
.meas tran ish1 AVG I(VsA1)+I(VsB1) FROM 0.002 TO 0.0029
.meas tran ish2 AVG I(VsA2)+I(VsB2) FROM 0.002 TO 0.0029
.meas tran idf1 AVG I(VsA1)-I(VsB1) FROM 0.002 TO 0.0029
.meas tran idf2 AVG I(VsA2)-I(VsB2) FROM 0.002 TO 0.0029
.meas tran da1 AVG V(DA1) FROM 0.002 TO 0.0029
.meas tran db1 AVG V(DB1) FROM 0.002 TO 0.0029
.meas tran da2 AVG V(DA2) FROM 0.002 TO 0.0029
.meas tran db2 AVG V(DB2) FROM 0.002 TO 0.0029
.meas tran pout AVG V(PV1P)*I(Bload) FROM 0.002 TO 0.0029
.meas tran pref AVG V(R1P)*I(Bref) FROM 0.002 TO 0.0029
.meas tran vd1s AVG V(PV1P,PV2P) FROM 0.0045 TO 0.006
.meas tran vd2s AVG V(PV2P,PV3P) FROM 0.0045 TO 0.006
.meas tran ish1s AVG I(VsA1)+I(VsB1) FROM 0.0045 TO 0.006
.meas tran ish2s AVG I(VsA2)+I(VsB2) FROM 0.0045 TO 0.006
.meas tran idf1s AVG I(VsA1)-I(VsB1) FROM 0.0045 TO 0.006
.meas tran idf2s AVG I(VsA2)-I(VsB2) FROM 0.0045 TO 0.006
.meas tran da1s AVG V(DA1) FROM 0.0045 TO 0.006
.meas tran db1s AVG V(DB1) FROM 0.0045 TO 0.006
.meas tran da2s AVG V(DA2) FROM 0.0045 TO 0.006
.meas tran db2s AVG V(DB2) FROM 0.0045 TO 0.006
.meas tran pouts AVG V(PV1P)*I(Bload) FROM 0.0045 TO 0.006
.meas tran prefs AVG V(R1P)*I(Bref) FROM 0.0045 TO 0.006
.meas tran betamax MAX V(BETA)
.meas tran stressmax MAX V(STRESS)
.meas tran im1r AVG V(IM1R) FROM 0.0045 TO 0.006
.meas tran im2r AVG V(IM2R) FROM 0.0045 TO 0.006
.meas tran i1 AVG I(Vi1) FROM 0.0045 TO 0.006
.meas tran i2 AVG I(Vi2) FROM 0.0045 TO 0.006
.meas tran i3 AVG I(Vi3) FROM 0.0045 TO 0.006
.lib SHUFFL~1.LIB
.end
