* S3 - + converter 1 power stage, ideal 12 V gate pulses (200 kHz, 50 %, 200 ns dead time)
.lib shuffler_models.lib
Vi1 a1 PV1P 0
Xpv1 a1 PV2P E1 pvmi_aiko
Dbp1 PV2P PV1P dbypass
Cpv1 PV1P PV2P 10n RSER=0.1
Vi2 a2 PV2P 0
Xpv2 a2 PV3P E2 pvmi_aiko
Dbp2 PV3P PV2P dbypass
Cpv2 PV2P PV3P 10n RSER=0.1
Vi3 a3 PV3P 0
Xpv3 a3 0 E3 pvmi_aiko
Dbp3 0 PV3P dbypass
Cpv3 PV3P 0 10n RSER=0.1
Bload PV1P 0 I=if(LOADSEL<0.5, V(PV1P)/Rmpp, Icc*min(1, time/200u))
Vir1 ra1 R1P 0
Xpvr1 ra1 R2P E1 pvmi_aiko
Dbpr1 R2P R1P dbypass
Cpvr1 R1P R2P 10n RSER=0.1
Vir2 ra2 R2P 0
Xpvr2 ra2 R3P E2 pvmi_aiko
Dbpr2 R3P R2P dbypass
Cpvr2 R2P R3P 10n RSER=0.1
Vir3 ra3 R3P 0
Xpvr3 ra3 0 E3 pvmi_aiko
Dbpr3 0 R3P dbypass
Cpvr3 R3P 0 10n RSER=0.1
Bref R1P 0 I=if(LOADSEL<0.5, V(R1P)/Rmpp, Icc*min(1, time/200u))
BE1 E1 0 V=table(CASE, 1,1000, 2,1000, 3,1000)
BE2 E2 0 V=table(CASE, 1,1000, 2,600, 3,1000)
BE3 E3 0 V=table(CASE, 1,1000, 2,1000, 3,400)
C1 PV1P PV2P 130u RSER=28m
C2 PV2P PV3P 130u RSER=28m
C3 PV2P PV3P 130u RSER=28m
C4 PV3P 0 130u RSER=28m
MTA1 PV1P gTA1 SWA1 SWA1 STD45N10F7
MBA1 SWA1 gBA1 PV3P PV3P STD45N10F7
RgTA1 gsTA1 gTA1 4.7
VgTA1 gsTA1 SWA1 PULSE(0 12 0.000e+00 5n 5n 2.300e-06 5.000e-06)
RgBA1 gsBA1 gBA1 4.7
VgBA1 gsBA1 PV3P PULSE(0 12 2.500e-06 5n 5n 2.300e-06 5.000e-06)
MTB1 PV1P gTB1 SWB1 SWB1 STD45N10F7
MBB1 SWB1 gBB1 PV3P PV3P STD45N10F7
RgTB1 gsTB1 gTB1 4.7
VgTB1 gsTB1 SWB1 PULSE(0 12 2.500e-06 5n 5n 2.300e-06 5.000e-06)
RgBB1 gsBB1 gBB1 4.7
VgBB1 gsBB1 PV3P PULSE(0 12 5.000e-06 5n 5n 2.300e-06 5.000e-06)
XL1 LA2_1 LB2_1 SWB1 SWA1 ERUC23-4R1K
VsA1 LA2_1 LA2s_1 0
XsA1 LA2s_1 PV2P TMCS1126 RSH=0.7m LSH=0.5n
VsB1 LB2_1 LB2s_1 0
XsB1 LB2s_1 PV2P TMCS1126 RSH=0.7m LSH=0.5n
.param Rmpp=8.148 Icc=10 CASE=1 LOADSEL=0
.option savepowers
.tran 0 0.0025 0.0024 2e-08
.step param CASE list 1 2 3
.step param LOADSEL list 0 1
.meas tran vstr AVG V(PV1P)
.meas tran istr AVG I(Bload)
.meas tran pout AVG V(PV1P)*I(Bload)
.meas tran pref AVG V(R1P)*I(Bref)
.meas tran v1 AVG V(PV1P,PV2P)
.meas tran i1 AVG I(Vi1)
.meas tran p1 AVG V(PV1P,PV2P)*I(Vi1)
.meas tran v2 AVG V(PV2P,PV3P)
.meas tran i2 AVG I(Vi2)
.meas tran p2 AVG V(PV2P,PV3P)*I(Vi2)
.meas tran v3 AVG V(PV3P)
.meas tran i3 AVG I(Vi3)
.meas tran p3 AVG V(PV3P)*I(Vi3)
.meas tran vr1 AVG V(R1P,R2P)
.meas tran ir1 AVG I(Vir1)
.meas tran vr2 AVG V(R2P,R3P)
.meas tran ir2 AVG I(Vir2)
.meas tran vr3 AVG V(R3P)
.meas tran ir3 AVG I(Vir3)
.meas tran ila1 AVG I(VsA1)
.meas tran ilb1 AVG I(VsB1)
.meas tran ilapp1 PP I(VsA1)
.meas tran ish1 AVG I(VsA1)+I(VsB1)
.meas tran vswamax1 MAX V(SWA1,PV3P)
.meas tran vswamin1 MIN V(SWA1,PV3P)
.meas tran vswbmax1 MAX V(SWB1,PV3P)
.meas tran pmta1 AVG P(MTA1)
.meas tran pmba1 AVG P(MBA1)
.meas tran pmtb1 AVG P(MTB1)
.meas tran pmbb1 AVG P(MBB1)
.meas tran pconv1 AVG P(MTA1)+P(MBA1)+P(MTB1)+P(MBB1)
.end
